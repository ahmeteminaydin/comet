* COMET AFE channel A - values from sheet COMET-ANA-01
* SiPM muon pulse: Q = 67 pC (~140 p.e. x 3e6 gain), 1.5 ns rise, 80 ns decay (simplified source)
.param Q=67p tr=1.5n tf=80n t0=20n
Bsipm 0 tp1 I = (time > t0) ? Q/(tf-tr)*(exp(-(time-t0)/tf) - exp(-(time-t0)/tr)) : 0
R1  tp1 0   50
C1  tp1 inp 100n
R2  vcc bias 15k
R3  bias 0   1k
C2  bias 0   1u
R9  bias inp 10k
Vcc vcc 0   5
* behavioral op-amp: A0 = 1e4, GBW ~ 1 GHz, output clamped to the rails
G1  0 x inp inn 1m
Rx  x 0 10Meg
Cx  x 0 0.159p
Bo  o 0 V = max(0.02, min(4.95, V(x)))
Ro  o out 10
R4  out inn 1k
C5  out inn 1.5p
R5  inn rg  50
C6  rg  0   10u
R6  out tp2 33
Cin tp2 0   3p
* behavioral comparator (TLV3501-like), threshold = baseline + 120 mV
Vth th 0 0.4325
Bc  tp3 0 V = 1.65*(1 + tanh((V(tp2) - V(th))/0.003))
.tran 0.1n 400n
.control
run
wrdata afe2.dat v(tp1) v(tp2) v(tp3)
meas tran base FIND v(tp2) AT=10n
meas tran pk2  MAX  v(tp2)
meas tran pk1  MAX  v(tp1)
meas tran tot  TRIG v(tp3) VAL=1.65 RISE=1 TARG v(tp3) VAL=1.65 FALL=1
.endc
.end
