* COMET - Analog front-end - channel A - DWG COMET-ANA-01
* Netlist generated from the COMET system schematic (sheet 9). Analysis: Muon pulse.
* Part values as shown on the sheet.

* =====================================================================
* COMET behavioural SPICE models  (ngspice and LTspice compatible)
* BAATCH, METU EE493-494. Generated with the COMET system schematic.
*
* These are simplified stand-ins for the real parts. They capture the
* behaviour that matters for COMET (gain, bandwidth, slew, delays,
* thresholds, timing) and nothing else. Replace them with vendor models
* when you have them; keep the pin order shown on each .subckt line.
* =====================================================================

* ---------------------------------------------------------------------
* Generic op-amp: single-pole, slew-limited.
*   VSW  = how close the output can swing to each rail (datasheet "output swing from rail")
*   VCMH = input common-mode headroom below V+ (inputs above V(vp)-VCMH are clipped there)
*   IB   = input bias current flowing out of each input
* Pins: non-inverting, inverting, output, V+, V-
* ---------------------------------------------------------------------
.subckt OPAMP_BEH inp inn out vp vn params: GBW=1G SR=1G VSW=0.05 VCMH=0 IB=0
.param CX={1m/(6.2832*GBW)}
.param IMAX={SR*CX}
Bip inp 0 I={IB}
Bin inn 0 I={IB}
Bg 0 x I={IMAX}*tanh(1m*(min(V(inp),V(vp)-{VCMH})-min(V(inn),V(vp)-{VCMH}))/{IMAX}) - 20m*(V(x)-max(V(vn),min(V(vp),V(x))))
Cx x 0 {CX}
Rx x 0 10Meg
Bo o 0 V=max(V(vn)+{VSW},min(V(vp)-{VSW},V(x)))
Ro o out 10
.ends OPAMP_BEH

* TI OPA356 (and OPA355, the version with an enable pin): 200 MHz GBW,
* unity-gain stable, 300 V/us, output within ~0.1 V of the rails (1 kOhm load),
* input common mode from V- to (V+) - 1.5 V, input bias current a few pA.
.subckt OPA356_BEH inp inn out vp vn
X1 inp inn out vp vn OPAMP_BEH GBW=200Meg SR=300Meg VSW=0.1 VCMH=1.5
.ends OPA356_BEH
.subckt OPA355_BEH inp inn out vp vn
X1 inp inn out vp vn OPAMP_BEH GBW=200Meg SR=300Meg VSW=0.1 VCMH=1.5
.ends OPA355_BEH

* TI LMH6629: 4 GHz GBW, stable only at gain >= 10 (decompensated), 1600 V/us.
* Its output only swings to within 0.8 V of the rails, so on a single supply it
* cannot sit at a 0.3 V baseline. Kept for reference; COMET uses the OPA356.
.subckt LMH6629_BEH inp inn out vp vn
X1 inp inn out vp vn OPAMP_BEH GBW=4G SR=1.6G VSW=0.8
.ends LMH6629_BEH

* ---------------------------------------------------------------------
* TI TLV3501 comparator: ~4.5 ns delay, push-pull rail-to-rail output,
* 6 mV internal hysteresis (datasheet typical). Enabled while SHDN is more
* than 1.7 V below V+ (tie SHDN to ground).
* Pins: non-inverting, inverting, output, V+, V-, SHDN
* ---------------------------------------------------------------------
.subckt TLV3501_BEH inp inn out vp vn shdn
Bs s0 0 V=0.5*(1+tanh((V(inp)-V(inn)+3m*(2*V(st)-1))/0.2m))
Rs1 s0 st 1k
Cs st 0 0.3p
Ben en 0 V=0.5*(1-tanh((V(shdn)-(V(vp)-1.3))/0.05))
Bc c 0 V=2*(V(vn)+(V(vp)-V(vn))*V(st)*V(en))
Rs c c1 50
T1 c1 0 c2 0 Td=3.8n Z0=50
Rt c2 0 50
Rf c2 c3 100
Cf c3 0 7p
Bo o 0 V=V(c3)
Ro o out 5
.ends TLV3501_BEH

* ---------------------------------------------------------------------
* 74LVC1G08 2-input AND gate at 3.3 V, ~3 ns delay.  Pins: A, B, Y
* ---------------------------------------------------------------------
.subckt AND2_LVC_BEH a b y
Bc c 0 V=6.6*0.25*(1+tanh((V(a)-1.65)/0.05))*(1+tanh((V(b)-1.65)/0.05))
Rs c c1 50
T1 c1 0 c2 0 Td=2.3n Z0=50
Rt c2 0 50
Rf c2 c3 100
Cf c3 0 7p
Bo o 0 V=V(c3)
Ro o y 10
.ends AND2_LVC_BEH

* ---------------------------------------------------------------------
* 74LVC1G14 Schmitt-trigger inverter at 3.3 V.
* Thresholds VT+ = 1.75 V, VT- = 1.05 V, ~3.5 ns delay.  Pins: A, Y
* ---------------------------------------------------------------------
.subckt SCHMITT_INV_LVC_BEH a y
Bs s0 0 V=3.3*0.5*(1+tanh((V(a)-(1.75-0.7*V(st)/3.3))/0.02))
Rs1 s0 st 1k
Cs st 0 0.3p
Bc c 0 V=2*(3.3-V(st))
Rs c c1 50
T1 c1 0 c2 0 Td=2.8n Z0=50
Rt c2 0 50
Rf c2 c3 100
Cf c3 0 7p
Bo o 0 V=V(c3)
Ro o y 10
.ends SCHMITT_INV_LVC_BEH

* ---------------------------------------------------------------------
* 74LVC1G74 D flip-flop at 3.3 V: rising-edge clock, active-low
* asynchronous clear and preset, ~3.5 ns clock-to-Q.
* Pins: D, CLK, Q, /Q, /CLR, /PRE, VCC, GND  (VCC, GND not used inside)
* ---------------------------------------------------------------------
.subckt DFF_LVC_BEH d clk q qn clrn pren vcc gnd
Bm 0 m I=1m*0.5*(1-tanh((V(clk)-1.65)/0.05))*(3.3*0.5*(1+tanh((V(d)-1.65)/0.05))-V(m)) - 5m*0.5*(1-tanh((V(clrn)-1.65)/0.05))*V(m) + 5m*0.5*(1-tanh((V(pren)-1.65)/0.05))*(3.3-V(m))
Cm m 0 0.5p
Rm m 0 1G
Bs 0 s I=1m*0.5*(1+tanh((V(clk)-1.65)/0.05))*(V(m)-V(s)) - 5m*0.5*(1-tanh((V(clrn)-1.65)/0.05))*V(s) + 5m*0.5*(1-tanh((V(pren)-1.65)/0.05))*(3.3-V(s))
Cs s 0 0.5p
Rs s 0 1G
Bc c 0 V=6.6*0.5*(1+tanh((V(s)-1.65)/0.05))
Rq c c1 50
T1 c1 0 c2 0 Td=2.8n Z0=50
Rt c2 0 50
Rf c2 c3 100
Cf c3 0 7p
Bo o 0 V=V(c3)
Ro o q 10
Bcn cn 0 V=6.6-V(c)
Rqn cn cn1 50
T2 cn1 0 cn2 0 Td=2.8n Z0=50
Rtn cn2 0 50
Rfn cn2 cn3 100
Cfn cn3 0 7p
Bon on 0 V=V(cn3)
Ron on qn 10
.ends DFF_LVC_BEH

* ---------------------------------------------------------------------
* 74LVC1G123 monostable at 3.3 V (idealised, NOT used in COMET).
* Width = Rext*Cext in this model, but the real part is much slower at
* small Cext: TI specifies 170-200 ns for Cext = 28 pF, Rext = 2 kOhm at
* 3.3 V (Rext >= 1 kOhm). It cannot make COMET's 50 ns pulses; the
* stretcher uses a 74LVC1G74 + RC + 74LVC1G14 one-shot instead.
* Pins: /A, B, /CLR, Q, /Q, VCC, CEXT, REXT/CEXT, GND
* ---------------------------------------------------------------------
.subckt MONO123_LVC_BEH an b clrn q qn vcc cext rext gnd
Rd b bd 2k
Cd bd 0 1p
Btr tr 0 V=3.3*0.5*(1+tanh((V(b)-1.65)/0.05))*0.5*(1-tanh((V(bd)-1.65)/0.05))*0.5*(1-tanh((V(an)-1.65)/0.05))*0.5*(1+tanh((V(clrn)-1.65)/0.05))
Rce cext 0 0.1
S1 rext 0 tr 0 MONO_DIS
.model MONO_DIS SW(Ron=5 Roff=1G Vt=1.65 Vh=0)
Bl 0 st I=2m*(0.5*(1+tanh((V(tr)-1.65)/0.05))*(3.3-V(st)) - 0.5*(1-tanh((V(tr)-1.65)/0.05))*min(1,0.5*(1+tanh((V(rext)-2.086)/0.02))+0.5*(1-tanh((V(clrn)-1.65)/0.05)))*V(st))
Cl st 0 0.5p
Rl st 0 1G
Bc c 0 V=6.6*0.5*(1+tanh((V(st)-1.65)/0.05))
Rq c c1 50
T1 c1 0 c2 0 Td=3.3n Z0=50
Rt c2 0 50
Rf c2 c3 100
Cf c3 0 7p
Bo o 0 V=V(c3)
Ro o q 10
Bcn cn 0 V=6.6-V(c)
Rqn cn cn1 50
T2 cn1 0 cn2 0 Td=3.3n Z0=50
Rtn cn2 0 50
Rfn cn2 cn3 100
Cfn cn3 0 7p
Bon on 0 V=V(cn3)
Ron on qn 10
.ends MONO123_LVC_BEH

* ---------------------------------------------------------------------
* onsemi MicroFC-60035 SiPM (6 mm, 35 um cells), microcell model.
* Fired and passive cells are lumped. Approximate parameters chosen to
* match ~3e6 gain at 2.5 V overvoltage, ~80 ns recovery, ~3.4 nF.
* Light: NPE photoelectrons arriving at T0 with plastic-scintillator
* timing (0.9 ns rise, 2.1 ns decay). Gain follows the overvoltage
* V(K,A) - Vbr(T), with Vbr(T) = 24.45 V + 21.5 mV/C * (T - 21 C).
* Pins: cathode, anode
* ---------------------------------------------------------------------
.subckt MICROFC60035_BEH k a params: NPE=140 T0=20n TEMP=21
.param NCELL=18980 CD=175f CQ=17f RQ=430k CG=50p
.param NPAS={NCELL-NPE}
Rqp k dp {RQ/NPAS}
Cqp k dp {CQ*NPAS}
Cdp dp a {CD*NPAS}
Rqf k df {RQ/NPE}
Cqf k df {CQ*NPE}
Cdf df a {CD*NPE}
Bav df a I={NPE*(CD+CQ)}*max(0,V(k,a)-(24.45+21.5m*({TEMP}-21)))*(exp(-max(time-{T0},0)/2.1n)-exp(-max(time-{T0},0)/0.9n))/1.2n
Cg k a {CG}
.ends MICROFC60035_BEH

* Schottky diode, approximate BAT54
.model BAT54 D(Is=2e-7 N=1.04 Rs=1.6 Cjo=9p M=0.33 Vj=0.35 Bv=30 Ibv=1e-5 Tt=5n)

* TI TS5A3159 analog switch: closes when CTL > 1.65 V.  Pins: A, B, CTL
.subckt TS5A3159_BEH a b ctl
S1 a b ctl 0 TS5A_SW
.model TS5A_SW SW(Ron=1 Roff=1G Vt=1.65 Vh=0.1)
.ends TS5A3159_BEH

* Ferrite bead (BLM18 class): inductive at low frequency, resistive at
* high frequency.  Pins: A, B
.subckt BEAD_BEH a b params: L=1u
L1 a m {L}
R1 m b 0.15
RP a b 470
.ends BEAD_BEH

* ---------------------------------------------------------------------
* Microchip MCP4728 quad 12-bit DAC (outputs only; I2C not modelled).
* Each output steps from code *0 to code * at TSTEP (0.5 mV per code).
* Pins: VDD, SCL, SDA, /LDAC, VOUTA, VOUTB, VOUTC, VOUTD, VSS
* ---------------------------------------------------------------------
.subckt MCP4728_BEH vdd scl sda ldacn va vb vc vd vss params: CA0=0 CA=840 CB0=0 CB=840 CC0=0 CC=0 CD0=0 CD=2048 TSTEP=10u
Bia ia 0 V=0.5m*({CA0}+({CA}-{CA0})*u(time-{TSTEP}))
Ria ia sa 1.5k
Csa sa 0 1n
Boa oa 0 V=V(sa)
Roa oa va 1
Bib ib 0 V=0.5m*({CB0}+({CB}-{CB0})*u(time-{TSTEP}))
Rib ib sb 1.5k
Csb sb 0 1n
Bob ob 0 V=V(sb)
Rob ob vb 1
Bic ic 0 V=0.5m*({CC0}+({CC}-{CC0})*u(time-{TSTEP}))
Ric ic sc 1.5k
Csc sc 0 1n
Boc oc 0 V=V(sc)
Roc oc vc 1
Bid id 0 V=0.5m*({CD0}+({CD}-{CD0})*u(time-{TSTEP}))
Rid id sd 1.5k
Csd sd 0 1n
Bod od 0 V=V(sd)
Rod od vd 1
.ends MCP4728_BEH

* ---- stimulus parameters ----
.param NPE=140
.param TEMP=21

* ---- circuit (from the sheet) ----
R1 tp1 0 50
C1 tp1 n1 100n
R2 p3v3_a vb 10k
R9 vb n1 10k
R3 vb 0 1k
C2 vb 0 1u
XU1 n1 n2 n3 p3v3_a 0 OPA356_BEH
C3 p3v3_a 0 100n
C4 p3v3_a 0 10u
R4 n2 n3 1k
C5 n2 n3 1.5p
R5 n2 n4 50
C6 n4 0 10u
R6 n3 tp2 33
C7 tp2 n5 100p
R7 n5 vb 1k
R8 n5 n6 1k
C8 n6 0 100p
XU2 n6 n7 to_peak_hold_a p3v3_a 0 OPA356_BEH
R27 n7 to_peak_hold_a 5.1k
R28 n8 n7 1k
C9 0 n8 10u

* ---- test bench ----
V_P3V3_A p3v3_a 0 3.3
V_SIPMBIAS sipm_vb 0 27.0
R_CARRIER sipm_vb sipm_k 1k
C_CARRIER sipm_k 0 100n
X_SIPM sipm_k sipm_a MICROFC60035_BEH NPE={NPE} T0=20n TEMP={TEMP}
* 30 cm of 50 ohm coax, 1.5 ns: five LC sections (15 nH, 6 pF, 0.2 ohm each)
L_CX1 sipm_a cxl1 15n
R_CX1 cxl1 cx1 0.2
C_CX1 cx1 0 6p
L_CX2 cx1 cxl2 15n
R_CX2 cxl2 cx2 0.2
C_CX2 cx2 0 6p
L_CX3 cx2 cxl3 15n
R_CX3 cxl3 cx3 0.2
C_CX3 cx3 0 6p
L_CX4 cx3 cxl4 15n
R_CX4 cxl4 cx4 0.2
C_CX4 cx4 0 6p
L_CX5 cx4 cxl5 15n
R_CX5 cxl5 tp1 0.2
C_CX5 tp1 0 6p
C_CMPIN tp2 0 3p
R_PHIN to_peak_hold_a 0 1Meg
C_PHIN to_peak_hold_a 0 3p

.tran 0.1n 1u 0 0.2n
* ngspice: ngspice COMET_AFE.cir, then type run and plot v(<net>)
* LTspice: open this file and press Run
.end
